// Verilog-AMS Behavioral Model
// Generated by circuit_preprocess pipeline
// Date: 2026-02-01 10:32:46
//
// Module: small_signal_vs_q4
// Model type: small_signal
// Intent: linear

`include "disciplines.vams"

module small_signal_vs_q4(
    inout electrical vd,  // drain
    inout electrical vg,  // gate
    inout electrical vs,  // source
    inout electrical vb   // bulk
);

    // Small-signal parameters (linearized at DC operating point)
    parameter real gm = 1.000000000000e-12;
    parameter real gds = 0.000000000000e+00;
    parameter real gmb = 0.000000000000e+00;

    analog begin
        real vgs, vds, vbs, id;

        // Terminal voltages
        vgs = V(vg, vs);
        vds = V(vd, vs);
        vbs = V(vb, vs);

        // Small-signal drain current
        id = gm*vgs + gds*vds;

        // Current contribution
        I(vd, vs) <+ id;
    end
endmodule
