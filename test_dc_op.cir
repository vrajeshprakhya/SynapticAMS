* NMOS DC Operating Point Example
* Simple NMOS transistor - find DC operating point

* Circuit (from ams-net.github.io/amsnet_1.0/0/0.cir)
M1 vd vg 0 0 NMOS W=1u L=1u
VDD vd 0 DC 1.8V
VGS vg 0 DC 1.0V

* NMOS model (Level 1 - simple)
.MODEL NMOS NMOS (LEVEL=1 VTO=0.4 KP=100u LAMBDA=0.02)

* DC Operating Point Analysis
.op

* Save all variables
.save all

* Control block for ngspice
.control
run
echo "DC Operating Point Analysis Complete!"
echo ""
echo "========================================"
echo "NODE VOLTAGES:"
echo "========================================"
print all
echo ""
echo "========================================"
echo "DEVICE OPERATING POINT INFO:"
echo "========================================"
show M1
echo ""
echo "Key Parameters:"
echo "  Gate Voltage (vg):     " vg
echo "  Drain Voltage (vd):    " vd
echo "  Drain Current (Id):    " -i(VDD)
echo "  VGS:                   " vg
echo "  VDS:                   " vd
.endc

.end
