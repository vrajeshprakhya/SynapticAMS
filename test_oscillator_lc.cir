* LC Oscillator Test Circuit
* Simple LC tank oscillator with NMOS negative resistance

* LC tank
L1 vout 0 1u IC=0
C1 vout 0 10p IC=0.1

* Negative resistance (cross-coupled NMOS pair for sustaining oscillation)
M1 vout vout 0 0 NMOS W=10u L=1u
M2 vout 0 0 0 NMOS W=5u L=1u

* Power supply
VDD vdd 0 DC 1.8V

* Bias resistor
R1 vdd vout 10k

* NMOS model
.MODEL NMOS NMOS (LEVEL=1 VTO=0.4 KP=100u LAMBDA=0.02)

* Initial conditions to start oscillation
.IC V(vout)=0.1

* Transient analysis: run for 10 periods at ~500 MHz (LC resonance)
* f = 1/(2*pi*sqrt(LC)) = 1/(2*pi*sqrt(1u*10p)) ≈ 503 MHz
* Period ≈ 2 ns, so 10 periods = 20 ns
.TRAN 10p 20n UIC

.END
