* Continuous-Time Linear Equalizer (CTLE)
* =========================================
* Subcircuit: ctle
* Ports: inp inn outp outn vdd gnd
*
* Degenerated NMOS differential pair with split RC source degeneration.
* RS||CS in each transistor's source path creates a frequency-dependent
* transconductance that peaks at high frequencies — compensating channel loss.
*
* Transfer function (differential half-circuit):
*   H(s) = −gm·RD · (1 + s·RS·CS) / (1 + gm·RS + s·RS·CS)
*         = −A∞ · (1 + s/ωz) / (1 + s/ωz · (1/(1+gm·RS)) + ...)
*
*   Zero:    fz = 1/(2π·RS·CS) = 1/(2π·200·800f) ≈ 995 MHz ≈ 1 GHz
*   DC gain: A0 = gm·RD/(1+gm·RS)
*   HF gain: A∞ = gm·RD  (CS shorts RS at high frequency)
*   Peaking: A∞/A0 = 1 + gm·RS  (factor: ≈ 2.3 → 7.3 dB boost)
*
* Transistor operating point (I_tail=2 mA, W=20µm, L=0.18µm):
*   ID (quiescent)  = 1 mA per transistor
*   VGS - VTH       = sqrt(ID/(KP/2·W/L)) = sqrt(1m/11.1m) = 0.30 V
*   VGS             ≈ 0.75 V  → input CM bias = 0.9 V works
*   gm              = sqrt(2·KP·W/L·ID) = sqrt(2·200µ·111·1m) ≈ 6.66 mA/V
*   Peaking         = 1 + 6.66m·200 = 2.33 → 7.3 dB
*   HF gain (A∞)    = 6.66m·500 Ω = 3.33 V/V = +10.5 dB
*   DC gain (A0)     = 3.33/2.33 = 1.43 V/V = +3.1 dB
*
* DC bias verification:
*   V_outp (quiescent) = VDD − ID·RD = 1.8 − 1m·500 = 1.3 V
*   V_s1               = Vinp − VGS  = 0.9 − 0.75 = 0.15 V
*   V_tail             = V_s1 − ID·RS = 0.15 − 1m·200 = −0.05 V  (ideal Itail OK)
*   V_DS1              = 1.3 − 0.15 = 1.15 V  >>  VGS−VTH = 0.30 V  (saturation ✓)
*
* Reference: Palermo, ECEN689 Lecture 18 — "RX FIR & CTLE Equalization",
*            Texas A&M University (ecen689/lecture18_ee689_rx_fir_ctle_eq)
* Compatible: ngspice 38+

.MODEL NMOS NMOS (LEVEL=1 VTO=0.45 KP=200u LAMBDA=0.02 GAMMA=0.4 PHI=0.65)

* ── Subcircuit ──────────────────────────────────────────────────────────────
.SUBCKT ctle  inp  inn  outp  outn  vdd  gnd

* Differential pair: bulk tied to gnd (NMOS bulk = p-substrate)
M1  outp  inp  s1  gnd  NMOS  W=20u  L=0.18u
M2  outn  inn  s2  gnd  NMOS  W=20u  L=0.18u

* Drain load resistors
RD1  vdd  outp  500
RD2  vdd  outn  500

* RC source degeneration (M1 path):
*   RS1 in series with M1 source → reduces gm at DC
*   CS1 in parallel with RS1 → bypasses RS1 at high freq → restores gm → peaking
RS1  s1  tail  200
CS1  s1  tail  800f

* RC source degeneration (M2 path)
RS2  s2  tail  200
CS2  s2  tail  800f

* Ideal tail current source — sinks 2 mA total (1 mA per transistor at quiescent)
I_tail  tail  gnd  DC  2m

.ENDS ctle

* ── Standalone Testbench ─────────────────────────────────────────────────────
* Run: ngspice ctle.cir
*
* AC sweep with differential half-circuit drive:
*   Vinp (ctle_inp) has AC 1 applied; Vinn fixed at DC 0.9 V CM.
*   Measures: vdb(ctle_outp) — non-inverting output gain in dB.
*
* Expected frequency response:
*   ≈ +3 dB  below 100 MHz  (DC gain A0 = 1.43 V/V)
*   Rising from ~1 GHz (zero) to ~3 GHz (pole = fz × (1+gm·RS))
*   ≈ +10 dB above 5 GHz  (HF gain A∞ = 3.33 V/V)
*   Peaking above DC = 7.3 dB  (1 + gm·RS = 2.33)
*
* Also runs .OP to verify DC bias point.

VDD   vdd  0  DC 1.8

* Differential inputs: Vinp carries AC stimulus; Vinn is CM reference
Vinp  ctle_inp  0  DC 0.9  AC 1
Vinn  ctle_inn  0  DC 0.9

X_CTLE  ctle_inp  ctle_inn  ctle_outp  ctle_outn  vdd  0  ctle

* Minimal load capacitors (1 fF) so the CTLE frequency response reflects the
* circuit transfer function without premature rolloff from an external load pole.
* Use 100 fF here when measuring loaded bandwidth in a real integration context.
Cout_p  ctle_outp  0  1f
Cout_n  ctle_outn  0  1f

.AC DEC 100 10Meg 50Gig

.PRINT AC vdb(ctle_outp) vdb(ctle_outn) vp(ctle_outp)

.END
