* Simple Ring Oscillator Test Case
* 3-stage CMOS ring oscillator

.title Simple VCO Test for Transient Model Generation

* Supply voltage
.param vdd=1.8

* Power supplies
VDD dd 0 DC {vdd}

* 3-stage ring oscillator
M1 n1 n3 0 0 NMOS W=1u L=0.18u
M2 n1 n3 dd dd PMOS W=2u L=0.18u

M3 n2 n1 0 0 NMOS W=1u L=0.18u
M4 n2 n1 dd dd PMOS W=2u L=0.18u

M5 n3 n2 0 0 NMOS W=1u L=0.18u
M6 n3 n2 dd dd PMOS W=2u L=0.18u

* Load capacitors (tune frequency)
C1 n1 0 10fF
C2 n2 0 10fF
C3 n3 0 10fF

* Initial condition to start oscillation
.ic V(n1)={vdd} V(n2)=0 V(n3)=0

* MOSFET models
.model NMOS NMOS (LEVEL=1 VTO=0.4 KP=200u LAMBDA=0.02 CGSO=0.1p CGDO=0.1p)
.model PMOS PMOS (LEVEL=1 VTO=-0.4 KP=100u LAMBDA=0.02 CGSO=0.1p CGDO=0.1p)

.END
