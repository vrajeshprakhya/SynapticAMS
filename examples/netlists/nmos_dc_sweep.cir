* NMOS DC Sweep Example (from AMS-Net circuit 0)
* Simple NMOS transistor with DC sweep on gate voltage

* Circuit (from ams-net.github.io/amsnet_1.0/0/0.cir)
M1 vd vg 0 0 NMOS W=1u L=1u
VDD vd 0 DC 1.8V
VGS vg 0 DC 0V

* NMOS model (Level 1 - simple)
.MODEL NMOS NMOS (LEVEL=1 VTO=0.4 KP=100u LAMBDA=0.02)

* DC Sweep: Vary gate voltage from 0V to 1.8V
.DC VGS 0 1.8 0.05

* Save variables for plotting
.save all

* Control block for ngspice
.control
run
echo "DC Sweep Complete!"
echo ""
echo "Gate Voltage (V) | Drain Current (A)"
echo "=====================================
"
print vg i(VDD)
echo ""
echo "To plot: plot -i(VDD) vs vg"
echo "To see all data: print all"
.endc

.end
