* NMOS AC Sweep Example
* Common-source amplifier - AC frequency response analysis

* Circuit (from ams-net.github.io/amsnet_1.0/0/0.cir)
* Modified for AC analysis with load resistor
M1 vout vg 0 0 NMOS W=10u L=1u
RD vdd vout 10k
VDD vdd 0 DC 1.8V

* Input: DC bias + AC signal
* DC 0.9V puts transistor in saturation region
* AC 1.0 is the small-signal amplitude (reference)
Vin vg 0 DC 0.9V AC 1.0

* NMOS model (Level 1 - simple)
.MODEL NMOS NMOS (LEVEL=1 VTO=0.4 KP=100u LAMBDA=0.02)

* AC Sweep Analysis
* Syntax: .ac dec <points_per_decade> <start_freq> <stop_freq>
*   dec = decade (logarithmic) sweep
*   lin = linear sweep
*   oct = octave sweep
.ac dec 10 1 1e9

* Save variables
.save all

* Control block for ngspice
.control
run
echo "AC Sweep Complete!"
echo ""
echo "Frequency Response Data:"
echo "========================"
echo "Frequency (Hz) | Vout Mag (dB) | Vout Phase (deg)"
echo "=================================================="
print frequency vdb(vout) vp(vout)
echo ""
echo "Key Metrics:"
echo "  DC Gain (at 1Hz):    " vdb(vout)[0] " dB"
echo "  Linear DC Gain:      " vm(vout)[0]
echo ""
echo "Plotting commands:"
echo "  plot vdb(vout)           - Magnitude (dB) vs frequency"
echo "  plot vp(vout)            - Phase (deg) vs frequency"
echo "  plot vm(vout)            - Magnitude (linear) vs frequency"
echo "  setplot                  - Show available plots"
.endc

.end
