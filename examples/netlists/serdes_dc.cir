* Minimal Analog SERDES — TX-to-RX DC Transfer Characteristic
* Purpose: Demonstrate SynapticAMS pipeline on an analog SerDes data path
* Architecture: TX Differential Driver → RC Channel → RX Differential Amplifier
* Analysis: DC sweep of TX input → observe RX differential output
*
* This is the data-path core of a SerDes IP:
*   - TX Driver converts single-ended data to differential CML signal
*   - Channel model represents a 10cm PCB trace (1Ω, 10pF per side)
*   - RX Amplifier recovers the differential signal with high gain (~166x)
*
* NOT included here: VCO/PLL (clock generation, requires transient analysis)

* =============================================================================
* BJT MODELS (Gummel-Poon NPN)
* =============================================================================
.model qnl npn(bf=80 rb=100 ccs=2pf tf=0.3ns tr=6ns cje=3pf cjc=2pf va=50)
.model qnr npn(bf=80 rb=100 ccs=2pf tf=0.3ns tr=6ns cje=3pf cjc=2pf va=50)

* =============================================================================
* DIFFERENTIAL PAIR SUBCIRCUIT (used for both TX driver and RX amplifier)
* BJT differential pair with current-mirror bias — classic SerDes building block
* Ports: vout_p vout_n vin_p vin_n vdd vss
* =============================================================================
.subckt diffpair vout_p vout_n vin_p vin_n vdd vss

* Differential input pair
q1 vout_p vin_p tail qnr
q2 vout_n vin_n tail qnl

* Resistive collector loads (CML topology — 10kΩ)
rc1 vout_p vdd 10k
rc2 vout_n vdd 10k

* Current mirror bias (Q3 diode-connected, Q4 mirrors tail current)
q3 bias bias vss qnl
q4 tail bias vss qnr
rbias bias vdd 20k

.ends diffpair

* =============================================================================
* SUPPLY VOLTAGES
* =============================================================================
VDD_P  vdd_p 0 DC 12
VDD_N  vdd_n 0 DC -12

* =============================================================================
* TX INPUT (differential data signal)
* Vtx_p is the swept input; Vtx_n is fixed at 0V (ground reference)
* Differential input = Vtx_p - Vtx_n, swept from -0.5V to +0.5V
* =============================================================================
Vtx_p  tx_in_p  0  DC 0
Vtx_n  tx_in_n  0  DC 0

* =============================================================================
* RX PATH — Differential Amplifier (recovers signal from channel)
* Instantiated first so the parser selects rx_out_p as the observed output node
* =============================================================================
Xrx_amp  rx_out_p rx_out_n rx_in_p rx_in_n vdd_p vdd_n diffpair

* RX output loads
Crx_p  rx_out_p  0  1p
Crx_n  rx_out_n  0  1p

* =============================================================================
* TX PATH — Differential Driver
* =============================================================================
Xtx_drv tx_out_p tx_out_n tx_in_p tx_in_n vdd_p vdd_n diffpair

* TX Output termination (50Ω CML termination)
Rtx_p  tx_out_p 0 50
Rtx_n  tx_out_n 0 50

* =============================================================================
* CHANNEL — RC Transmission Line Model (10cm PCB trace)
* 0.1 Ω/cm * 10cm = 1Ω series resistance
* 1 pF/cm * 10cm = 10pF shunt capacitance
* =============================================================================
Rchan_p  tx_out_p  rx_in_p  1
Rchan_n  tx_out_n  rx_in_n  1
Cchan_p  rx_in_p   0        10p
Cchan_n  rx_in_n   0        10p

* =============================================================================
* DC SWEEP: Sweep TX positive input from -0.5V to +0.5V
* Observe RX differential output (rx_out_p tracks the gain)
* The differential pair's linear region spans approximately ±0.5V
* =============================================================================
.DC Vtx_p -0.5 0.5 0.005

.PRINT DC v(rx_out_p) v(rx_out_n) v(tx_out_p) v(tx_out_n)

.END
