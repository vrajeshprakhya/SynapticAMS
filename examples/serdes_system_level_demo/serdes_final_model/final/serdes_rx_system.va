// Verilog-AMS Behavioral Model
// Generated by circuit_preprocess pipeline
// Date: 2026-05-02 19:08:11
//
// Module: serdes_rx_system
// Model type: LUT_2D
// Intent: coupled_nonlinear

`include "disciplines.vams"

module serdes_rx_system(
    output electrical final_out,
    input electrical tx_p_src,
    input electrical tx_n_src
);

    // 2D Lookup table parameters
    parameter real x1_min = 0.000000000000e+00;
    parameter real x1_max = 0.000000000000e+00;
    parameter integer n1 = 10;
    parameter real x2_min = 0.000000000000e+00;
    parameter real x2_max = 0.000000000000e+00;
    parameter integer n2 = 10;
    parameter real output_resistance = 1.0;  // Output resistance (Ohms) for numerical stability

    // Embedded lookup table data as individual parameters (10×10 grid)
    parameter real lut_0 = 6.527175000000e-01;
    parameter real lut_1 = 5.753616000000e-01;
    parameter real lut_2 = 5.143191000000e-01;
    parameter real lut_3 = 4.571550000000e-01;
    parameter real lut_4 = 4.076298000000e-01;
    parameter real lut_5 = 3.906168000000e-01;
    parameter real lut_6 = 3.906165000000e-01;
    parameter real lut_7 = 3.906165000000e-01;
    parameter real lut_8 = 3.906165000000e-01;
    parameter real lut_9 = 3.906165000000e-01;
    parameter real lut_10 = 7.009710000000e-01;
    parameter real lut_11 = 6.348436000000e-01;
    parameter real lut_12 = 5.737561000000e-01;
    parameter real lut_13 = 5.138637000000e-01;
    parameter real lut_14 = 4.571780000000e-01;
    parameter real lut_15 = 4.075346000000e-01;
    parameter real lut_16 = 3.906165000000e-01;
    parameter real lut_17 = 3.906165000000e-01;
    parameter real lut_18 = 3.906165000000e-01;
    parameter real lut_19 = 3.906165000000e-01;
    parameter real lut_20 = 7.568392000000e-01;
    parameter real lut_21 = 6.957539000000e-01;
    parameter real lut_22 = 6.347280000000e-01;
    parameter real lut_23 = 5.737599000000e-01;
    parameter real lut_24 = 5.140572000000e-01;
    parameter real lut_25 = 4.569015000000e-01;
    parameter real lut_26 = 4.066520000000e-01;
    parameter real lut_27 = 3.906165000000e-01;
    parameter real lut_28 = 3.906165000000e-01;
    parameter real lut_29 = 3.906165000000e-01;
    parameter real lut_30 = 8.125947000000e-01;
    parameter real lut_31 = 7.555053000000e-01;
    parameter real lut_32 = 6.956660000000e-01;
    parameter real lut_33 = 6.347256000000e-01;
    parameter real lut_34 = 5.738220000000e-01;
    parameter real lut_35 = 5.135614000000e-01;
    parameter real lut_36 = 4.555856000000e-01;
    parameter real lut_37 = 4.057113000000e-01;
    parameter real lut_38 = 3.906165000000e-01;
    parameter real lut_39 = 3.906165000000e-01;
    parameter real lut_40 = 8.618287000000e-01;
    parameter real lut_41 = 8.123209000000e-01;
    parameter real lut_42 = 7.554119000000e-01;
    parameter real lut_43 = 6.956307000000e-01;
    parameter real lut_44 = 6.347251000000e-01;
    parameter real lut_45 = 5.732308000000e-01;
    parameter real lut_46 = 5.122922000000e-01;
    parameter real lut_47 = 4.540391000000e-01;
    parameter real lut_48 = 4.143892000000e-01;
    parameter real lut_49 = 3.993209000000e-01;
    parameter real lut_50 = 8.788872000000e-01;
    parameter real lut_51 = 8.620351000000e-01;
    parameter real lut_52 = 8.125657000000e-01;
    parameter real lut_53 = 7.558969000000e-01;
    parameter real lut_54 = 6.962232000000e-01;
    parameter real lut_55 = 6.347246000000e-01;
    parameter real lut_56 = 5.726223000000e-01;
    parameter real lut_57 = 5.112536000000e-01;
    parameter real lut_58 = 4.569615000000e-01;
    parameter real lut_59 = 4.332068000000e-01;
    parameter real lut_60 = 8.788872000000e-01;
    parameter real lut_61 = 8.788872000000e-01;
    parameter real lut_62 = 8.628676000000e-01;
    parameter real lut_63 = 8.138793000000e-01;
    parameter real lut_64 = 7.571640000000e-01;
    parameter real lut_65 = 6.968309000000e-01;
    parameter real lut_66 = 6.347470000000e-01;
    parameter real lut_67 = 5.721492000000e-01;
    parameter real lut_68 = 5.104550000000e-01;
    parameter real lut_69 = 4.736906000000e-01;
    parameter real lut_70 = 8.788872000000e-01;
    parameter real lut_71 = 8.788872000000e-01;
    parameter real lut_72 = 8.788872000000e-01;
    parameter real lut_73 = 8.632604000000e-01;
    parameter real lut_74 = 8.154256000000e-01;
    parameter real lut_75 = 7.581780000000e-01;
    parameter real lut_76 = 6.973717000000e-01;
    parameter real lut_77 = 6.347480000000e-01;
    parameter real lut_78 = 5.717709000000e-01;
    parameter real lut_79 = 5.193784000000e-01;
    parameter real lut_80 = 8.788872000000e-01;
    parameter real lut_81 = 8.788872000000e-01;
    parameter real lut_82 = 8.788872000000e-01;
    parameter real lut_83 = 8.788872000000e-01;
    parameter real lut_84 = 8.533025000000e-01;
    parameter real lut_85 = 8.108677000000e-01;
    parameter real lut_86 = 7.589694000000e-01;
    parameter real lut_87 = 6.976101000000e-01;
    parameter real lut_88 = 6.347427000000e-01;
    parameter real lut_89 = 5.722012000000e-01;
    parameter real lut_90 = 8.788872000000e-01;
    parameter real lut_91 = 8.788872000000e-01;
    parameter real lut_92 = 8.788872000000e-01;
    parameter real lut_93 = 8.788872000000e-01;
    parameter real lut_94 = 8.679366000000e-01;
    parameter real lut_95 = 8.333419000000e-01;
    parameter real lut_96 = 7.927559000000e-01;
    parameter real lut_97 = 7.475532000000e-01;
    parameter real lut_98 = 6.960410000000e-01;
    parameter real lut_99 = 6.345220000000e-01;

    analog begin : analog_block
        real v_ideal;
        real v1, v2;
        real i1_real, i2_real;
        integer i1, i2, i1p, i2p;
        integer idx00, idx01, idx10, idx11;
        real w1, w2;
        real z00, z01, z10, z11;
        real z0, z1;

        // Read input voltages
        v1 = V(tx_p_src);
        v2 = V(tx_n_src);

        // Clamp to table bounds
        if (v1 < x1_min) v1 = x1_min;
        if (v1 > x1_max) v1 = x1_max;
        if (v2 < x2_min) v2 = x2_min;
        if (v2 > x2_max) v2 = x2_max;

        // Compute continuous indices (with guards for constant axes)
        if (abs(x1_max - x1_min) < 1e-12)
            i1_real = 0.0;  // Constant axis
        else
            i1_real = (v1 - x1_min) * (n1 - 1) / (x1_max - x1_min);

        if (abs(x2_max - x2_min) < 1e-12)
            i2_real = 0.0;  // Constant axis
        else
            i2_real = (v2 - x2_min) * (n2 - 1) / (x2_max - x2_min);

        // Integer indices (floor)
        i1 = $floor(i1_real);
        i2 = $floor(i2_real);

        // Ensure indices stay in bounds
        if (i1 < 0) i1 = 0;
        if (i1 >= n1 - 1) i1 = n1 - 2;
        if (i2 < 0) i2 = 0;
        if (i2 >= n2 - 1) i2 = n2 - 2;

        i1p = i1 + 1;
        i2p = i2 + 1;

        // Interpolation weights
        w1 = i1_real - i1;
        w2 = i2_real - i2;

        // Compute flat indices (row-major)
        idx00 = i1 * n2 + i2;
        idx01 = i1 * n2 + i2p;
        idx10 = i1p * n2 + i2;
        idx11 = i1p * n2 + i2p;

        // Lookup corner values using case statement
        case (idx00)
            0: z00 = lut_0;
            1: z00 = lut_1;
            2: z00 = lut_2;
            3: z00 = lut_3;
            4: z00 = lut_4;
            5: z00 = lut_5;
            6: z00 = lut_6;
            7: z00 = lut_7;
            8: z00 = lut_8;
            9: z00 = lut_9;
            10: z00 = lut_10;
            11: z00 = lut_11;
            12: z00 = lut_12;
            13: z00 = lut_13;
            14: z00 = lut_14;
            15: z00 = lut_15;
            16: z00 = lut_16;
            17: z00 = lut_17;
            18: z00 = lut_18;
            19: z00 = lut_19;
            20: z00 = lut_20;
            21: z00 = lut_21;
            22: z00 = lut_22;
            23: z00 = lut_23;
            24: z00 = lut_24;
            25: z00 = lut_25;
            26: z00 = lut_26;
            27: z00 = lut_27;
            28: z00 = lut_28;
            29: z00 = lut_29;
            30: z00 = lut_30;
            31: z00 = lut_31;
            32: z00 = lut_32;
            33: z00 = lut_33;
            34: z00 = lut_34;
            35: z00 = lut_35;
            36: z00 = lut_36;
            37: z00 = lut_37;
            38: z00 = lut_38;
            39: z00 = lut_39;
            40: z00 = lut_40;
            41: z00 = lut_41;
            42: z00 = lut_42;
            43: z00 = lut_43;
            44: z00 = lut_44;
            45: z00 = lut_45;
            46: z00 = lut_46;
            47: z00 = lut_47;
            48: z00 = lut_48;
            49: z00 = lut_49;
            50: z00 = lut_50;
            51: z00 = lut_51;
            52: z00 = lut_52;
            53: z00 = lut_53;
            54: z00 = lut_54;
            55: z00 = lut_55;
            56: z00 = lut_56;
            57: z00 = lut_57;
            58: z00 = lut_58;
            59: z00 = lut_59;
            60: z00 = lut_60;
            61: z00 = lut_61;
            62: z00 = lut_62;
            63: z00 = lut_63;
            64: z00 = lut_64;
            65: z00 = lut_65;
            66: z00 = lut_66;
            67: z00 = lut_67;
            68: z00 = lut_68;
            69: z00 = lut_69;
            70: z00 = lut_70;
            71: z00 = lut_71;
            72: z00 = lut_72;
            73: z00 = lut_73;
            74: z00 = lut_74;
            75: z00 = lut_75;
            76: z00 = lut_76;
            77: z00 = lut_77;
            78: z00 = lut_78;
            79: z00 = lut_79;
            80: z00 = lut_80;
            81: z00 = lut_81;
            82: z00 = lut_82;
            83: z00 = lut_83;
            84: z00 = lut_84;
            85: z00 = lut_85;
            86: z00 = lut_86;
            87: z00 = lut_87;
            88: z00 = lut_88;
            89: z00 = lut_89;
            90: z00 = lut_90;
            91: z00 = lut_91;
            92: z00 = lut_92;
            93: z00 = lut_93;
            94: z00 = lut_94;
            95: z00 = lut_95;
            96: z00 = lut_96;
            97: z00 = lut_97;
            98: z00 = lut_98;
            99: z00 = lut_99;
            default: z00 = lut_0;
        endcase

        case (idx01)
            0: z01 = lut_0;
            1: z01 = lut_1;
            2: z01 = lut_2;
            3: z01 = lut_3;
            4: z01 = lut_4;
            5: z01 = lut_5;
            6: z01 = lut_6;
            7: z01 = lut_7;
            8: z01 = lut_8;
            9: z01 = lut_9;
            10: z01 = lut_10;
            11: z01 = lut_11;
            12: z01 = lut_12;
            13: z01 = lut_13;
            14: z01 = lut_14;
            15: z01 = lut_15;
            16: z01 = lut_16;
            17: z01 = lut_17;
            18: z01 = lut_18;
            19: z01 = lut_19;
            20: z01 = lut_20;
            21: z01 = lut_21;
            22: z01 = lut_22;
            23: z01 = lut_23;
            24: z01 = lut_24;
            25: z01 = lut_25;
            26: z01 = lut_26;
            27: z01 = lut_27;
            28: z01 = lut_28;
            29: z01 = lut_29;
            30: z01 = lut_30;
            31: z01 = lut_31;
            32: z01 = lut_32;
            33: z01 = lut_33;
            34: z01 = lut_34;
            35: z01 = lut_35;
            36: z01 = lut_36;
            37: z01 = lut_37;
            38: z01 = lut_38;
            39: z01 = lut_39;
            40: z01 = lut_40;
            41: z01 = lut_41;
            42: z01 = lut_42;
            43: z01 = lut_43;
            44: z01 = lut_44;
            45: z01 = lut_45;
            46: z01 = lut_46;
            47: z01 = lut_47;
            48: z01 = lut_48;
            49: z01 = lut_49;
            50: z01 = lut_50;
            51: z01 = lut_51;
            52: z01 = lut_52;
            53: z01 = lut_53;
            54: z01 = lut_54;
            55: z01 = lut_55;
            56: z01 = lut_56;
            57: z01 = lut_57;
            58: z01 = lut_58;
            59: z01 = lut_59;
            60: z01 = lut_60;
            61: z01 = lut_61;
            62: z01 = lut_62;
            63: z01 = lut_63;
            64: z01 = lut_64;
            65: z01 = lut_65;
            66: z01 = lut_66;
            67: z01 = lut_67;
            68: z01 = lut_68;
            69: z01 = lut_69;
            70: z01 = lut_70;
            71: z01 = lut_71;
            72: z01 = lut_72;
            73: z01 = lut_73;
            74: z01 = lut_74;
            75: z01 = lut_75;
            76: z01 = lut_76;
            77: z01 = lut_77;
            78: z01 = lut_78;
            79: z01 = lut_79;
            80: z01 = lut_80;
            81: z01 = lut_81;
            82: z01 = lut_82;
            83: z01 = lut_83;
            84: z01 = lut_84;
            85: z01 = lut_85;
            86: z01 = lut_86;
            87: z01 = lut_87;
            88: z01 = lut_88;
            89: z01 = lut_89;
            90: z01 = lut_90;
            91: z01 = lut_91;
            92: z01 = lut_92;
            93: z01 = lut_93;
            94: z01 = lut_94;
            95: z01 = lut_95;
            96: z01 = lut_96;
            97: z01 = lut_97;
            98: z01 = lut_98;
            99: z01 = lut_99;
            default: z01 = lut_0;
        endcase

        case (idx10)
            0: z10 = lut_0;
            1: z10 = lut_1;
            2: z10 = lut_2;
            3: z10 = lut_3;
            4: z10 = lut_4;
            5: z10 = lut_5;
            6: z10 = lut_6;
            7: z10 = lut_7;
            8: z10 = lut_8;
            9: z10 = lut_9;
            10: z10 = lut_10;
            11: z10 = lut_11;
            12: z10 = lut_12;
            13: z10 = lut_13;
            14: z10 = lut_14;
            15: z10 = lut_15;
            16: z10 = lut_16;
            17: z10 = lut_17;
            18: z10 = lut_18;
            19: z10 = lut_19;
            20: z10 = lut_20;
            21: z10 = lut_21;
            22: z10 = lut_22;
            23: z10 = lut_23;
            24: z10 = lut_24;
            25: z10 = lut_25;
            26: z10 = lut_26;
            27: z10 = lut_27;
            28: z10 = lut_28;
            29: z10 = lut_29;
            30: z10 = lut_30;
            31: z10 = lut_31;
            32: z10 = lut_32;
            33: z10 = lut_33;
            34: z10 = lut_34;
            35: z10 = lut_35;
            36: z10 = lut_36;
            37: z10 = lut_37;
            38: z10 = lut_38;
            39: z10 = lut_39;
            40: z10 = lut_40;
            41: z10 = lut_41;
            42: z10 = lut_42;
            43: z10 = lut_43;
            44: z10 = lut_44;
            45: z10 = lut_45;
            46: z10 = lut_46;
            47: z10 = lut_47;
            48: z10 = lut_48;
            49: z10 = lut_49;
            50: z10 = lut_50;
            51: z10 = lut_51;
            52: z10 = lut_52;
            53: z10 = lut_53;
            54: z10 = lut_54;
            55: z10 = lut_55;
            56: z10 = lut_56;
            57: z10 = lut_57;
            58: z10 = lut_58;
            59: z10 = lut_59;
            60: z10 = lut_60;
            61: z10 = lut_61;
            62: z10 = lut_62;
            63: z10 = lut_63;
            64: z10 = lut_64;
            65: z10 = lut_65;
            66: z10 = lut_66;
            67: z10 = lut_67;
            68: z10 = lut_68;
            69: z10 = lut_69;
            70: z10 = lut_70;
            71: z10 = lut_71;
            72: z10 = lut_72;
            73: z10 = lut_73;
            74: z10 = lut_74;
            75: z10 = lut_75;
            76: z10 = lut_76;
            77: z10 = lut_77;
            78: z10 = lut_78;
            79: z10 = lut_79;
            80: z10 = lut_80;
            81: z10 = lut_81;
            82: z10 = lut_82;
            83: z10 = lut_83;
            84: z10 = lut_84;
            85: z10 = lut_85;
            86: z10 = lut_86;
            87: z10 = lut_87;
            88: z10 = lut_88;
            89: z10 = lut_89;
            90: z10 = lut_90;
            91: z10 = lut_91;
            92: z10 = lut_92;
            93: z10 = lut_93;
            94: z10 = lut_94;
            95: z10 = lut_95;
            96: z10 = lut_96;
            97: z10 = lut_97;
            98: z10 = lut_98;
            99: z10 = lut_99;
            default: z10 = lut_0;
        endcase

        case (idx11)
            0: z11 = lut_0;
            1: z11 = lut_1;
            2: z11 = lut_2;
            3: z11 = lut_3;
            4: z11 = lut_4;
            5: z11 = lut_5;
            6: z11 = lut_6;
            7: z11 = lut_7;
            8: z11 = lut_8;
            9: z11 = lut_9;
            10: z11 = lut_10;
            11: z11 = lut_11;
            12: z11 = lut_12;
            13: z11 = lut_13;
            14: z11 = lut_14;
            15: z11 = lut_15;
            16: z11 = lut_16;
            17: z11 = lut_17;
            18: z11 = lut_18;
            19: z11 = lut_19;
            20: z11 = lut_20;
            21: z11 = lut_21;
            22: z11 = lut_22;
            23: z11 = lut_23;
            24: z11 = lut_24;
            25: z11 = lut_25;
            26: z11 = lut_26;
            27: z11 = lut_27;
            28: z11 = lut_28;
            29: z11 = lut_29;
            30: z11 = lut_30;
            31: z11 = lut_31;
            32: z11 = lut_32;
            33: z11 = lut_33;
            34: z11 = lut_34;
            35: z11 = lut_35;
            36: z11 = lut_36;
            37: z11 = lut_37;
            38: z11 = lut_38;
            39: z11 = lut_39;
            40: z11 = lut_40;
            41: z11 = lut_41;
            42: z11 = lut_42;
            43: z11 = lut_43;
            44: z11 = lut_44;
            45: z11 = lut_45;
            46: z11 = lut_46;
            47: z11 = lut_47;
            48: z11 = lut_48;
            49: z11 = lut_49;
            50: z11 = lut_50;
            51: z11 = lut_51;
            52: z11 = lut_52;
            53: z11 = lut_53;
            54: z11 = lut_54;
            55: z11 = lut_55;
            56: z11 = lut_56;
            57: z11 = lut_57;
            58: z11 = lut_58;
            59: z11 = lut_59;
            60: z11 = lut_60;
            61: z11 = lut_61;
            62: z11 = lut_62;
            63: z11 = lut_63;
            64: z11 = lut_64;
            65: z11 = lut_65;
            66: z11 = lut_66;
            67: z11 = lut_67;
            68: z11 = lut_68;
            69: z11 = lut_69;
            70: z11 = lut_70;
            71: z11 = lut_71;
            72: z11 = lut_72;
            73: z11 = lut_73;
            74: z11 = lut_74;
            75: z11 = lut_75;
            76: z11 = lut_76;
            77: z11 = lut_77;
            78: z11 = lut_78;
            79: z11 = lut_79;
            80: z11 = lut_80;
            81: z11 = lut_81;
            82: z11 = lut_82;
            83: z11 = lut_83;
            84: z11 = lut_84;
            85: z11 = lut_85;
            86: z11 = lut_86;
            87: z11 = lut_87;
            88: z11 = lut_88;
            89: z11 = lut_89;
            90: z11 = lut_90;
            91: z11 = lut_91;
            92: z11 = lut_92;
            93: z11 = lut_93;
            94: z11 = lut_94;
            95: z11 = lut_95;
            96: z11 = lut_96;
            97: z11 = lut_97;
            98: z11 = lut_98;
            99: z11 = lut_99;
            default: z11 = lut_0;
        endcase

        // Bilinear interpolation
        z0 = z00 * (1.0 - w2) + z01 * w2;
        z1 = z10 * (1.0 - w2) + z11 * w2;
        v_ideal = z0 * (1.0 - w1) + z1 * w1;

        // Use current source with output resistance (Thevenin equivalent)
        I(final_out) <+ (v_ideal - V(final_out)) / output_resistance;
    end
endmodule
