* Test Fixed SPICE SerDes
.include /tmp/flattened_serdes.cir
.end
