* Test OSDI model loading

.title OSDI load test

.control
echo "Loading OSDI model..."
osdi /tmp/test_model.osdi
echo "Listing models..."
listmod
quit
.endc

.END
