* 3-Stage Ring Oscillator
* Simple CMOS ring oscillator with 3 inverter stages

* Inverter 1: vin -> v1
M1p v1 vin vdd vdd PMOS W=2u L=1u
M1n v1 vin 0 0 NMOS W=1u L=1u

* Inverter 2: v1 -> v2
M2p v2 v1 vdd vdd PMOS W=2u L=1u
M2n v2 v1 0 0 NMOS W=1u L=1u

* Inverter 3: v2 -> vin (feedback)
M3p vin v2 vdd vdd PMOS W=2u L=1u
M3n vin v2 0 0 NMOS W=1u L=1u

* Power supply
VDD vdd 0 DC 1.8V

* Load capacitors (gate cap + interconnect)
C1 v1 0 10f
C2 v2 0 10f
C3 vin 0 10f

* MOSFET models
.MODEL NMOS NMOS (LEVEL=1 VTO=0.4 KP=100u LAMBDA=0.02)
.MODEL PMOS PMOS (LEVEL=1 VTO=-0.4 KP=50u LAMBDA=0.02)

* Initial conditions to break symmetry and start oscillation
.IC V(vin)=0.1 V(v1)=1.8 V(v2)=0

* Transient analysis: run for several oscillation periods
* Ring osc frequency ≈ 1/(6*RC) where R ≈ 1/gm ≈ 10k, C = 10f
* f ≈ 1/(6*10k*10f) ≈ 1.7 GHz
* Period ≈ 0.6 ns, so 20 periods = 12 ns
.TRAN 10p 12n UIC

.END
